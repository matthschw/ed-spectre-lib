// (C) Copyright Efficient Power Conversion Corporation. All rights reserved.
// **************************************************************************
//* Version History:
//* 1.00: 09/23/2013 - Initial model creation
//* 1.01: 03/17/2014 - Changed "scale" to "scl" to avoid conflict with system parameters
//* 1.02: 05/28/2019 - Fixed a typo

simulator lang=spectre

subckt EPC8004 (gatein drainin sourcein)

parameters scl=50.4/25
parameters aWg=scl*25 A1=scl*1.593 k2=2.03 k3=0.177 rpara=0.1412/scl
+      aITc=0.0036 arTc=-0.0036 x0_0=1.02 x0_1=0.1789 x0_1_TC=0.004
+      dgs1=scl*4.3e-7 dgs2=scl*2.6e-13 dgs3=.8 dgs4=.23
+      ags1=(scl*15.6E-12 + 13.1E-12) ags2=scl*8.875E-12 ags3=1.56 ags4=0.26
+      ags5=scl*-2.01E-13 ags6=-7.99 ags7=2.46
+      agd1=scl*0.167E-12 agd2=scl*3.523E-12 agd3=-0.889 agd4=1.044
+      agd5=scl*1.14E-12 agd6=-5.658 agd7=4.445
+      asd1=(scl*2.72E-12 + 1.9E-12) asd2=scl*9.00E-12 asd3=-6.1585 asd4=3.1215
+      asd5=scl*6.37E-12 asd6=-42.978 asd7=28.23

rd (drainin drain) resistor r=(0.75*rpara*(1-arTc*(temp-25)))
rs (sourcein source) resistor r=(0.25*rpara*(1-arTc*(temp-25)))
rg (gatein gate) resistor r=(.6)

rcsdconv (drain source) resistor r=(1E9/aWg)
rcgsconv (gate source) resistor r=(1E9/aWg)
rcgdconv (gate drain) resistor r=(1E9/aWg)

gswitch drain source bsource i=( (v(drain,source)>0) ?
+	(A1*(1-aITc*(temp-25))*log(1.0+exp((v(gate,source)-k2)/k3))*
+	v(drain,source)/(1 + max(x0_0+x0_1*(1-x0_1_TC*(temp-25))*v(gate,source),0.2)*v(drain,source)) ) :
+	(-A1*(1-aITc*(temp-25))*log(1.0+exp((v(gate,drain)-k2)/k3))*
+	v(source,drain)/(1 + max(x0_0+x0_1*(1-x0_1_TC*(temp-25))*v(gate,drain),0.2)*v(source,drain)) ) )

ggsdiode gate source bsource i=( (v(gate,source)>10) ?
+	(0.5*aWg/1077*(dgs1*(exp((10.0)/dgs3)-1)+dgs2*(exp((10.0)/dgs4)-1))) :
+	(0.5*aWg/1077*(dgs1*(exp((v(gate,source))/dgs3)-1)+dgs2*(exp((v(gate,source))/dgs4)-1)))  )

ggddiode gate drain bsource i=( (v(gate,drain)>10) ?
+	(0.5*aWg/1077*(dgs1*(exp((10.0)/dgs3)-1)+dgs2*(exp((10.0)/dgs4)-1))) :
+	(0.5*aWg/1077*(dgs1*(exp((v(gate,drain))/dgs3)-1)+dgs2*(exp((v(gate,drain))/dgs4)-1))) )

C_GS  (gate source) bsource c=(ags1)
G_CGS1 (gate source) bsource q=(0.5*ags2*ags4*log(1+exp((v(gate,source)-ags3)/ags4))+
+	ags5*ags7*log(1+exp((v(source,drain)-ags6)/ags7)) )

C_GD  (gate drain) bsource c=(agd1)
G_CGD1 (gate drain) bsource q=(0.5*ags2*ags4*log(1+exp((v(gate,drain)-ags3)/ags4))+
+	agd2*agd4*log(1+exp((v(gate,drain)-agd3)/agd4))+agd5*agd7*log(1+exp((v(gate,drain)-agd6)/agd7)) )

C_SD  (source drain) bsource c=(asd1)
G_CSD1 (source drain) bsource q=(asd2*asd4*log(1+exp((v(source,drain)-asd3)/asd4))+
+	asd5*asd7*log(1+exp((v(source,drain)-asd6)/asd7)) )

ends EPC8004
